# Ansys Electronics Desktop project, version 2024.1
materials:
  vacuum: permittivity=1

design HFSSDesign1 (HFSS, HFSS Terminal Network, model units mm)
geometry:
  Polyline1 = polyline((0mm, 0mm, 0mm) (0mm, 0mm, 3mm))
  Polyline2 = polyline((0mm, 0mm, 3mm) (0mm, 0mm, 33mm), section rectangle width=0mm height=30mm orient=X)
  Polyline3 = polyline((0mm, -2mm, 16mm) (0mm, -24mm, 28mm), section rectangle width=0mm height=40mm orient=X)
  Polyline3_1 = Polyline3.duplicate_mirror(point=(0mm, 0mm, 16mm), normal=(0mm, 1mm, 0mm))
  Rectangle1 = rectangle(corner=(-80mm, -80mm, 0mm), x_size=160mm, y_size=160mm)
