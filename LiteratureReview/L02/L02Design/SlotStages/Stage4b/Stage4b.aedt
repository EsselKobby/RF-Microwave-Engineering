# Ansys Electronics Desktop project, version 2024.1
materials:
  vacuum: permittivity=1

design HFSSDesign1 (HFSS, HFSS Terminal Network, model units mm)
geometry:
  Ground = rectangle(corner=(-50mm, -50mm, 0mm), x_size=100mm, y_size=100mm)
  Feedline = rectangle(corner=(50mm, 27.46mm, 0mm), x_size=-66.6mm, y_size=-4.92mm)
  Rectangle3 = rectangle(corner=(-16.6mm, 24.2mm, 0mm), x_size=32mm, y_size=-1.66mm)
  Rectangle4 = rectangle(corner=(-16.6mm, 27.46mm, 0mm), x_size=32mm, y_size=-1.66mm)
  Feedline.subtract(Rectangle3, Rectangle4)
  Rectangle5 = rectangle(corner=(-1.25mm, 39.4mm, 0mm), x_size=2.5mm, y_size=(-78.8 -2.5) mm)
  Rectangle5_Split1 = Rectangle5.split(plane=ZX, keep=Both)
  Rectangle5.move(0mm, 2.5mm, 0mm)
  Rectangle5.rotate(axis=Z, angle=-45deg)
  Rectangle6 = rectangle(corner=(-12.5mm, 14mm, 0mm), x_size=25mm, y_size=-2.5mm)
  ls5 = rectangle(corner=(0mm, 0.3mm, 0mm), x_size=-35.2mm, y_size=-0.6mm)
  fs2 = rectangle(corner=(-35.2mm, 0.3mm, 0mm), x_size=-4.6mm, y_size=-0.6mm)
  fs2.rotate(axis=Z, angle=-90deg)
  fs2.move(-34.9mm, -35.5mm, 0mm)
  ls4 = rectangle(corner=(-39.8mm, 0.3mm, 0mm), x_size=-10.6mm, y_size=-0.6mm)
  ls4.move(15.2mm, 4mm, 0mm)
  fs2.unite(ls4, ls5)
