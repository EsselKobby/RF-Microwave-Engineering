# Ansys Electronics Desktop project, version 2024.1
materials:
  vacuum: permittivity=1

design HFSSDesign1 (HFSS, HFSS Terminal Network, model units mm)
geometry:
  Ground = rectangle(corner=(-50mm, -50mm, -1.6mm), x_size=100mm, y_size=100mm)
  Feedline = rectangle(corner=(50mm, 27.46mm, 0mm), x_size=-66.6mm, y_size=-4.92mm)
  Rectangle3 = rectangle(corner=(-16.6mm, 24.2mm, 0mm), x_size=32mm, y_size=-1.66mm)
  Rectangle4 = rectangle(corner=(-16.6mm, 27.46mm, 0mm), x_size=32mm, y_size=-1.66mm)
  Feedline.subtract(Rectangle3, Rectangle4)
  Rectangle5 = rectangle(corner=(-1.25mm, 39.4mm, -1.6mm), x_size=2.5mm, y_size=(-78.8 -2.5) mm)
  Rectangle5_Split1 = Rectangle5.split(plane=ZX, keep=Both)
  Rectangle5.move(0mm, 2.5mm, 0mm)
  Rectangle5.rotate(axis=Z, angle=-45deg)
  full_slot = rectangle(corner=(-12.5mm, 14mm, -1.6mm), x_size=25mm, y_size=-2.5mm)
  ls7 = rectangle(corner=(-0.3mm, 0mm, -1.6mm), x_size=0.6mm, y_size=-38.8mm)
  ws3 = rectangle(corner=(-0.3mm, -38.8mm, -1.6mm), x_size=0.6mm, y_size=-4.6mm)
  fs1 = rectangle(corner=(-0.3mm, -43.4mm, -1.6mm), x_size=0.6mm, y_size=-21.85mm)
  ws3.rotate(axis=Z, angle=-90deg)
  ws3.move(39.1mm, -38.5mm, 0mm)
  fs1.move(-4mm, 26.45mm, 0mm)
  fs1.unite(ls7, ws3)
  ls5 = rectangle(corner=(0mm, 0.3mm, -1.6mm), x_size=-35.2mm, y_size=-0.6mm)
  fs2 = rectangle(corner=(-35.2mm, 0.3mm, -1.6mm), x_size=-4.6mm, y_size=-0.6mm)
  fs2.rotate(axis=Z, angle=-90deg)
  fs2.move(-34.9mm, -35.5mm, 0mm)
  ls4 = rectangle(corner=(-39.8mm, 0.3mm, -1.6mm), x_size=-10.6mm, y_size=-0.6mm)
  ls4.move(15.2mm, 4mm, 0mm)
  fs2.unite(ls4, ls5)
  full_slot.unite(fs1, fs2, Rectangle5_Split1, Rectangle5)
  Box1 [vacuum] = box(corner=(-50mm, 50mm, -1.6mm), size=(100mm, -100mm, 1.6mm))
  Ground.subtract(full_slot)
  port = rectangle(corner=(50mm, 22.54mm, 0mm), y_size=4.92mm, z_size=-1.6mm)
boundaries and excitations:
  PerfE1: Perfect E Objects=Feedline
  PerfE2: Perfect E Objects=Ground
  1: Lumped Port Objects=port LumpedPortType=Modal Modes{Mode1{IntLine{(50, 25, -1.6) -> (50, 25, 0)} CharImp=Zpi}} Impedance=50ohm
setups:
  Setup1: HfssDriven Frequency=1.28GHz MaxDeltaS=0.02 MaximumPasses=6 MinimumPasses=1 MinimumConvergedPasses=1 PercentRefinement=30 BasisOrder=1 PortAccuracy=2 DrivenSolverType="Direct Solver"
    sweep Sweep: 0.64GHz to 1.92GHz, 401 points; Type=Fast SaveFields
source amplitudes:
  1:1: 1V 0deg
reports:
  S Parameter Plot 1: dB(S(1,1)) vs Freq on Setup1 : Sweep
